{
    name: "keccak",
    clock_primary: "clk",
    reset_primary: "rst_n",
    bus_device: "reg",
    bus_host: "",

    regwidth: "32",
    registers: [
        { multireg:
          { name: "din",
            desc: "Subword of input of Keccak module",
            count: "2",
            cname: "din",
            swaccess: "wo",
            fields: [
                { bits: "31:0"
                }
            ],
          }
        },
        { multireg:
          { name: "dout",
            desc: "Subword of results.",
            count: "2",
            cname: "dout",
            swaccess: "ro",
            hwaccess: "hwo",
            hwext: "true",
            fields: [
                { bits: "31:0"
                }
            ],
          }
        },
	{ name: "CTRL1"
	  desc: " Configures and enable the accelerator"
	  swaccess: "rw",
	  hwaccess: "hrw",
	  hwext: "true",
	  fields: [
	      { bits: "0", name: "START",
		desc: "Make the keccack starts"
	      }	
	      { bits: "1", name: "DIN_VALID",
		desc: "Input of Keccak module is valid"
	      }
	      { bits: "2", name: "LAST_BLOCK",
		desc: "Permutation is over"
	      } 
	  ]	
	},
	{ name: "STATUS"
	  desc: " Contains status information about the Keccak"
	  swaccess: "ro",
	  hwaccess: "hwo",
	  hwext: "true",
	  fields: [
	      { bits: "0", name: "DOUT_VALID",
		desc: "Output of keccack is valid"
	      }	
	      { bits: "1", name: "BUFFER_FULL",
		desc: "Buffer of Keccak module is full"
	      }	
	      { bits: "2", name: "READY",
		desc: "Keccak is ready to receive a new input ?"
	      }
	  ]	
	}
    ],
}
